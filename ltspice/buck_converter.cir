* 12 V to 5 V Buck Converter Testbench
* Nominal design: 5 V output at 1 A load
* 100 kHz switching frequency
* Duty cycle approx 0.417
* Includes ESR/DCR parasitics (fixed-duty, fixed-load baseline)

.param Vin=12
.param Vout=5
.param Fs=100k
.param Tsw=1/Fs
.param Ton=0.417*Tsw
.param Iload=1
.param Rload={Vout/Iload}
.param L1=100u
.param Cout=220u
.param DCR=0.07
.param ESR=0.05

* Input supply
Vin in 0 {Vin}

* PWM signal to drive the high-side switch
Vgate gate 0 PULSE(0 5 0 10n 10n {Ton} {Tsw})

* High-side switch (ideal switch with finite on-resistance)
S1 in sw gate 0 SWMOD

* Flyback diode
D1 0 sw Dsch

* Inductor and series DCR
Rind sw nL {DCR}
L1 nL out1 {L1}

* Capacitor with ESR and output node (load connects at out1, before ESR)
Rcap out1 out2 {ESR}
C1 out2 0 {Cout}

* Load resistor for nominal condition
Rload out1 0 {Rload}

* Simulation setup
.tran 0 5m 0 100n

* Parameter sweeps to study input and load variations
* .step param Vin list 10 12 14
* .step param Rload list 10 5

* Optional measurements
* .meas tran Vout_avg AVG V(out1)
* .meas tran I_Lavg AVG I(L1)
* .meas tran Vout_pp PP V(out1)
* .meas tran Load_current_param param Iload

* Ideal switch model
.model SWMOD SW(Ron=0.03 Roff=1Meg Vt=2.5 Vh=0.1)

* Schottky diode model
.model Dsch D(Is=1e-9 Rs=0.02 N=1.2 Cjo=50p M=0.5 Eg=0.6)

.end
