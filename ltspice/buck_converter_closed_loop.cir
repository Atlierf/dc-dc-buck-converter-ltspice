* Closed-loop educational buck-converter testbench for LTspice
* Target: 12 V nominal to 5 V, 1 A maximum
* 100 kHz switching; 100 uH inductor; 220 uF output capacitor
* Behavioral PI control and PWM comparator; tune and verify before relying on results.
* This is not a manufacturer-specific controller model.

.param VIN_DC=12
.param VREF=5
.param FS=100k
.param TSW={1/FS}
.param LVAL=100u
.param COUT=220u
* Bourns SRR1260-101M datasheet max DCR (180 mOhm) and Panasonic EEU-FR1C221 max 100 kHz impedance/ESR (130 mOhm)
.param DCR=180m
.param CESR=130m
.param KP=0.015
.param KI=65
.param KD=1.2

* Input, stepped for line-regulation study
VBus in 0 {VIN_DC}
.step param VIN_DC list 10 12 14

* PWM carrier: linear ramp from 0 to 1 once per switching period.
* The 1 ns falling edge resets the carrier at the end of each period.
Vtri ramp 0 PULSE(0 1 0 {TSW-1n} 1n 0 {TSW})

* PID controller: duty command is bounded from 5% to 90%.
* Error is positive when the output is below the 5 V reference.
* Band-limited derivative on V(out) (tau = 8 us, f_pole = 19.9 kHz) adds phase lead
* around the 1.07 kHz LC resonance while attenuating 100 kHz switching ripple.
Berr err 0 V=VREF-V(out)
Cdiff out d_node 1n
Rdiff d_node 0 8k
Bctrl duty 0 V=limit(0.4167+KP*V(err)+V(ci)-KD*V(d_node),0.05,0.90)

* Anti-windup behavior: freeze integration if saturated and error pushes farther
* into saturation. Cint=1 F makes injected current numerically equal to d(Vci)/dt.
Bint 0 ci I=if(V(duty)>=0.899 & V(err)>0,0,if(V(duty)<=0.051 & V(err)<0,0,KI*V(err)))
Cint ci 0 1 IC=0
Rleak ci 0 100Meg

* High-side switch: assumed idealized voltage-controlled switch (ground-referenced 0-5 V gate drive;
* no floating/bootstrap MOSFET gate driver is modeled).
Bgate gate 0 V=if(V(ramp)<V(duty),5,0)
S1 in sw gate 0 SWMOD
.model SWMOD SW(Ron=30m Roff=1Meg Vt=2.5 Vh=0.1)

* Freewheel Schottky diode: onsemi MBRS340 (40 V, 3 A) from LTspice 17.2.4 standard.dio
D1 0 sw MBRS340
.model MBRS340 D(Is=22.6u Rs=.042 N=1.094 Cjo=480p M=.61 Eg=.69 Xti=2 Iave=3 Vpk=40 mfg=OnSemi type=Schottky)

* Inductor and its winding resistance
Rind sw nL {DCR}
L1 nL out {LVAL}

* Output capacitor with ESR. Load is connected to the output node, before ESR.
Rcap out cap  {CESR}
C1 cap 0 {COUT} IC=0

* Load step: 0.5 A nominal at 5 V, increasing to 1 A at 2 ms.
* This behavioral current load scales with output voltage like a resistor.
Bload out 0 I=if(time<2m,V(out)/10,V(out)/5)

* Transient simulation and steady-state measurements around the load step.
* Note on polarity: I(VBus) is positive into VBus(+), so delivered power is -V(in)*I(VBus).
* I(Bload) flows from out to 0, so load power is +V(out)*I(Bload).
.options plotwinsize=0
.tran 0 5m 0 100n startup
.meas tran VPRE AVG V(out) FROM=1.5m TO=1.9m
.meas tran VPOST AVG V(out) FROM=4m TO=4.9m
.meas tran VPP_POST PP V(out) FROM=4m TO=4.9m
.meas tran ILPP_POST PP I(L1) FROM=4m TO=4.9m
.meas tran VMIN_STEP MIN V(out) FROM=2m TO=4.99m
.meas tran VMAX_STEP MAX V(out) FROM=2m TO=4.99m
.meas tran T_BAND_LAST FIND time WHEN abs(V(out)-5)=0.1 TD=2m CROSS=LAST
.meas tran TSETTLE_MS PARAM (T_BAND_LAST-2m)*1000
.meas tran PIN_POST AVG -V(in)*I(VBus) FROM=4m TO=4.9m
.meas tran POUT_POST AVG V(out)*I(Bload) FROM=4m TO=4.9m
.meas tran EFF_POST PARAM 100*POUT_POST/PIN_POST

.end
